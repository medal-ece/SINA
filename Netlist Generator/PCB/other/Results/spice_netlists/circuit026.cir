* SPICE netlist for circuit026.png
X1 VIO #RST VDD REGIN #SUSPEND SUSPEND GPIO0 GPIO1 GPIO1 GPIO3 GPIO3 DETECT DCD D DCD D- DSR DSR CP2014VREG CP2014VREG RXD RTS CTS SUBCKT
X2 VBUS D- CC1 CC2 CC2 SBU1 SBU2 GND SUBCKT
X3 JP4 N1 RST GPIO3 GPIO3 #SUSP #SUSP SUSP SUBCKT
X4 RTS RXD RXD TXD DSR DCD DCD N2 Modem SUBCKT
X5 RXD RXD TXD CTS CTS JP1 SUBCKT
R6 3.45V N3 1k
R7 N4 GND 1k
R8 N5 GND 1k
X9 ZOK VBUS ZOK SUBCKT
R10 3.45V N6 1k
.end
