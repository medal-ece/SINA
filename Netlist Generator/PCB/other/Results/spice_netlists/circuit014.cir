* SPICE netlist for circuit014.png
X1 N1 SDA SDA SCL SOW SUBCKT
X2 VDD XI INTI CLK SCL VBAT SDA VSS SUBCKT
R3 T R1 1k
R4 SDA SDA 1k
R5 VCC XT 1k
.end
