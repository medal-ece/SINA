* SPICE netlist for circuit009.png
X1 VDD WS SELECT SELECT BCLK GND SUBCKT
X2 JP2 N1 N2 N3 N4 N5 SUBCKT
R3 DATA N6 1k
R4 N7 GND 1k
.end
