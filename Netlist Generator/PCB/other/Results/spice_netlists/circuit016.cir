* SPICE netlist for circuit016.png
X1 LEDA N1 N2 LEDCT EMIT TCRT1000_VERT TCRT1000_VERT COL SUBCKT
X2  SUBCKT
X3  SUBCKT
X4  SUBCKT
R5 N3 N4 1k
R6 N5 N6 1k
R7 1BK VIN 1k
R8 N7 N8 1k
X9 N9 3314J 3314J 3314J 3314J SUBCKT
.end
