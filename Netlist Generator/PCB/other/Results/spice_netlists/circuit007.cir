* SPICE netlist for circuit007.png
X1 GND SDA SDA OSCL SUBCKT
X2 A1 INT SCL SDA SDA A1 A2 A2 SUBCKT
X3 A1 A1 A2 SUBCKT
X4 JP3 SCL SCL INT INT SUBCKT
X5 VCC SDA SDA SCL SUBCKT
R6 N1 N2 1k
R7 VCC N3 1k
R8 VCC N4 1k
R9 N5 INT 1k
.end
