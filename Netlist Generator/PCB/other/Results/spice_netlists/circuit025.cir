* SPICE netlist for circuit025.png
X1 VCCIO VS CPO BRA CPI BRB STEP OUTA1 STANDBY OUT1B STANDBY OUT2B ENABLE OUTB2 CLK MS1 VCP SPREAD VREF SPREAD 5YOUT UART DIAG INDEX GND SUBCKT
X2 N1 N2 N3 N4 N5 N6 SUBCKT
X3 N7 N8 N9 N10 N11 N12 N13 N14 N15 N16 SUBCKT
R4 STEP STEP 1k
R5 Pa GND 1k
R6 Pack Pack 1k
R7 N17 GND 1k
R8 H GND 1k
X9 N18 N19 GND SUBCKT
X10 N20 VREE VREE N21 N22 SUBCKT
R11 N23 GND 1k
R12 N24 N25 1k
R13 N26 GND 1k
X14 H SUBCKT
.end
