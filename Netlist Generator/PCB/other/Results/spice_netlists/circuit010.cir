* SPICE netlist for circuit010.png
X1 VDD SNS OUT SNS OUT SYNC VDD SUBCKT
X2 LEDA OUT OUT N1 SUBCKT
R3 1K 1K 1k
R4 R1 10K 1k
.end
