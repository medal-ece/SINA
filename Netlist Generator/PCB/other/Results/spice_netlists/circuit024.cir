* SPICE netlist for circuit024.png
X1 N1 VDDIO_0 VDDIO VDDIO VDDIO GND GND_1 GND_2 GND GND_4 SUBCKT
X2 JP3 N2 N3 N4 N5 N6 N7 N8 N9 N10 N11 N12 SUBCKT
X3 RESET AREF AREF AREF A1 A1 A2 A4 A4 SCK MOSI MOSI MISO DO TX D4 SUBCKT
X4 2MB VCC VSS SUBCKT
X5 N13 EINTO SERCOM1.0 EINT1 SERCOM1.1 EINT2 SERCOM1 VREFA SERCOM1 VREFB 12SFS0 AINS 12SDO PA06 12SDI PA07 12SFS1 PA08 SERCOM3 PA09 SERCOM3 PA10 PA27 PA11 SWCLK PA12 SERCOM1.3 PA13 PA14 PA15 SUBCKT
X6 N14 D8_NEOPIX DO GND SUBCKT
X7 VBUS D D- ID GND SUBCKT
X8 VDD VBAT PROG STAT VSS SUBCKT
X9 JSTPH JSTPH JSTPH SUBCKT
X10 P4 OUT EN GND SUBCKT
X11 PB00 N15 PB00 SERCOM4.0 PB01 SERCOM4.1 NEOPIX SERCOM4.2 NEOPIX OSPICS PB04 125CK1 PB05 125MCK1 PB06 SERCOM4.2 PB07 SERCOM4.3 125CKO 125MCKO SERCOM1 SERCOM1 SERCOM5.1 SERCOM5.0 SUBCKT
R12 N16 GND 1k
R13 N17 3V3 1k
R14 HOK HOK 1k
X15 10K SUBCKT
X16 N18 N19 N20 N21 SUBCKT
X17 N22 N23 GND SUBCKT
R18 DMG341 EN 1k
R19 N24 N25 1k
X20 VBAT VBAT VBAT Q3 N26 Q3 SUBCKT
X21 22KD135 22KD135 22KD135 SUBCKT
R22 N27 GND 1k
.end
