* SPICE netlist for circuit040.png
X1 USB RESET EXTINT SDA SCL TX_READY MISO RXMOSI SEL MW33TX2 RX2 R2433 STAT TIMEPULSE SAFEBOOT V unshifted SUBCKT
X2 DTR RXI -TXO VCC CTS GND Radio 3.3V SUBCKT
X3 FENCE_STAT STAT PPS_STAT RESET SAFE INT N1 N2 SUBCKT
X4 SCK SDA -UCC GND PTH SUBCKT
X5 OUT OUT EN 1.0uF 1.0uF 3.3U 3.3U 3.3U SUBCKT
X6 N3 N4 N5 N6 N7 N8 N9 N10 N11 N12 SUBCKT
X7 SCK SDA UCC GND Quiic SUBCKT
X8 K N13 K D6 SUBCKT
X9 SCK SDA UCC GND N14 Right SUBCKT
X10 VBUS D D. CC1 CC2 SHLD GND GND SUBCKT
R11 GND GND 1k
.end
