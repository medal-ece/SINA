* SPICE netlist for circuit044.png
X1 N1 3.3V GND SDA P19 BTN_P16 P15 P14 P13 BTN_R BTN_P12 BTN_B P10 P9 BTN_DN BTN_L P7 P6 BTN_A P4 BTN_UP P3 SUBCKT
R2 P1 P1 1k
R3 P1 P1 1k
R4 BTN_B P1 1k
R5 P1 P1 1k
X6 GND UCC SDA SCL SUBCKT
R7 P1 P1 1k
R8 P1 P1 1k
R9 P1 P1 1k
R10 P1 P1 1k
.end
