* SPICE netlist for circuit017.png
X1 FGPMMOPA6H VCC NC NRESET GND VBACKUP NC VBACKUP NC FIX NO NC NC NC RTCM GND 1PPS TX GND RX EX_ANT SUBCKT
X2 ENABLE VBACKUP VBACKUP FIX TX RX RX 1PPS 1PPS SUBCKT
X3  SUBCKT
R4 3.3V Lok 1k
X5  SUBCKT
R6 R1 R1 1k
.end
