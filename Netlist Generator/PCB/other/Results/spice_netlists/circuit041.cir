* SPICE netlist for circuit041.png
X1 VBAT VDD SCK MOSI IREF D2 VCOMH D3 VCC D4 D5 BS1 D6 2.2uF D7 GND GND CS VLSS RESET VSS D W RD C2P C2N C1P C1N SUBCKT
X2 DO D1 N1 N2 SUBCKT
X3 SCL- ISDA UCC IGND- SUBCKT
X4 SCL- SDA UCC GND- SUBCKT
.end
