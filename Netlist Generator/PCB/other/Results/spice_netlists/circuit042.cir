* SPICE netlist for circuit042.png
X1 N1 D14 D15 SDA SCL MOSI MISO SCK CS D4 D5 N2 D6 D7 LED_DATA D13 D16 D17 PCM_CLK DAC ADC DAC BKLITE RST_SCREEN D24 INT D26 D27 N3 SUBCKT
X2 MICBIAS LEFTMIC 0.1uF GND GND ADMP401 ADMP401 SUBCKT
X3 N4 RST_ATTINY BTN_LEFT XTAL2 BTN_A ADC7 ADC6 ADC5 ADC4 BTN_CENTER ADC2 BTN_RIGHT BTN_DOWN SUBCKT
X4 WM8960 N5 DCVDD VMID DBVDD MICBIAS SPKVDD1 SPKVDD2 AVDD HEADPHONE_L HEADPHONE_R ADCLRC DACLRC MONO_OUT BCLK ADCDAT SPEAKER_RP DACDAT SPEAKER_RN MCLK SPEAKER TYP SPEAKER_LN TYP LINPUT1 DGND LINPUT2 AGND LINPUT3 SPKGND1 RINPUT1 SPKGND2 RINPUT2 RINPUT3 GNDPADDLE SUBCKT
X5 OUT VCC 10nF PADDLE MHz SUBCKT
X6 VCC SDI RST_SCREEN LEDK SCK LEDA CS D GND SDO TFT SUBCKT
R7 GND RIGHTMIC 1k
X8 MISO N6 SCL SDA RST_ATTINY N7 MISO SDA SUBCKT
X9 CENT BTN_UP BTN_DOWN GND SUBCKT
X10 SCL 5DA VCC GND SUBCKT
X11 LS2 N8 CVS SUBCKT
X12 RGB VDDI 131_LI DI DO DI SUBCKT
X13 DI TRGB DO DO -H SUBCKT
X14 RGB VDD 1³ILI DI DO DI SUBCKT
X15 TRGB DO DO W52812B SUBCKT
X16 LS2 N9 CVS N10 N11 N12 SUBCKT
X17 RGB VDD i_i II I³ILI I³ILI DI SUBCKT
X18 RGB VDD 131_NI 131_NI W52812B 131_NI DI D3 DI SUBCKT
X19 DO W52812B TRGB W52812B W52812B SUBCKT
.end
