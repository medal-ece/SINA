* SPICE netlist for circuit032.png
X1 VDDIO GPIOO VDD GPIO1 LDO_IN GPIO2 OUT GPIO3 VDD_1V1 GPIO4 ADC_VDD GPIO5 GPIOE RESET GPIO7 GPIO8 USB GPIO9 USB_D- GPIO10 GPIO11 GPIO12 XIN GPIO13 XOUT GPIO14 GPIO15 GPIO16 GPIO17 SWDCK GPIO18 SWDIO GPIO19 SPI_CIPO QSPI GPIO21 QSPI SPI_SCK QSPI SPI_COPI QSPI_SD3 GPIO24 QSPI_SCLK GPIO25 QSPI_CS GPIO26 GPIO27 TESTEN GPIO28 EPAD GPIO29 SUBCKT
X2 RAW GND RESET 3.3V A3 A2 A1 AO SCK CIPO SPI_COPI SPI_CS N1 SUBCKT
X3 OUT OUT CZ 10UF 10uF 3.3V SUBCKT
X4 TXO RXO GND GND N2 N3 N4 N5 N6 N7 TX1 RX1 N8 SUBCKT
X5 VBUS D- GND GND JP14 SUBCKT
X6 VDD RGB WS2812 TP3- WS2812-2020 WS2812-2020 WS2812-2020 SUBCKT
X7 SCL- SDA UCC GND Quiic SUBCKT
X8 VDD CS QSPI QSPI QSPI QSPI 0.1uF QSPI W25QXX128MBIT SUBCKT
X9 M VBUS D D USB USB SHLD GND GND SUBCKT
.end
