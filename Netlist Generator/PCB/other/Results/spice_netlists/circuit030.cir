* SPICE netlist for circuit030.png
X1 N1 X2 X2 SUBCKT
X2 JP2 SUBCKT
R3 X1 N2 1k
R4 R1 MMBT2222 1k
X5 VBAT EN USB GPIO13 GPIO12 GPIO11 GPIO10 GPIO9 GPIO6 GPIO5 GPIOSCL GPIOSDA SUBCKT
R6 10K 10K 1k
R7 3.3V 1K 1k
X8 RESET N3 AREF GND GPIOAO GPIOA1 GPIOA2 GPIOA3 GPIOA4 GPIOA5 GPIOSCK GPIOMOSI GPIOMISO GPIORX GPIOTX NC N4 JP1 SUBCKT
X9 RESET N5 AREF GND GPIOAO GPIOA1 GPIOA2 GPIOA3 GPIOA4 GPIOA5 GPIOSCK GPIOMOSI GPIOMISO GPIORX GPIOTX NC JP3 N6 N7 N8 N9 SUBCKT
.end
