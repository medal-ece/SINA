* SPICE netlist for circuit049.png
X1 VDD SDA VDD_10 SCL CS SDOI SDX SCX SDO_AUX OCS GND INT1 GND INT2 SUBCKT
X2 SCL- SDA UCC GND- SUBCKT
R3 INT1 N1 1k
.end
