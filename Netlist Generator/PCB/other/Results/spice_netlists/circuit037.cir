* SPICE netlist for circuit037.png
X1 SWDIO VCC SWDIO GND SWDCLK GND SWO KEY TDI GNDDTCT NRESET SWDIO SUBCKT
X2 N1 RESET VDDIO VDDIN VDDIO VDDCORE SER0 SER0 SER0 SER0 SER2 DGIG VDDANA SER2 SER2 32.768kHz MOSI SER1 XOUT32 SER1 PA02 MISO PA03 SER5 PA04 SER5 AIN5 SER3 PA06 SER3 PA07 SER3 AIN10 USB_D AIN11 TX_LED AIN2 PA28 PB09 SWCLK SWDIO GNDANA PB10 GND SER4 GND SER5 GND SER5 SUBCKT
X3 D1 DO RESET N2 D2 D3 D4 D5 D6 D7 D8 D9 SUBCKT
X4 N3 N4 N5 N6 A3 A2 A1 AQ SCK MISO MOSI SS SUBCKT
X5 OUT OUT EN GND 2.2uF SUBCKT
X6 VCC VCC VCC A GND GND SUBCKT
R7 SCL SDA 1k
X8 N7 D13 D13 N8 SUBCKT
.end
