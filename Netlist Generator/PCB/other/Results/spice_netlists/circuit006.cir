* SPICE netlist for circuit006.png
X1 SDA INT INT NC VDD GND SUBCKT
X2 OUT OUT GND SUBCKT
X3 JP1 N1 INT INT SDA SCL SUBCKT
R4 VIN N2 1k
R5 3.3V N3 1k
R6 VIN N4 1k
R7 3.3V N5 1k
X8 N6 N7 N8 N9 N10 SUBCKT
X9 N11 N12 N13 N14 N15 SUBCKT
.end
