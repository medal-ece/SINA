* SPICE netlist for circuit048.png
X1 ISCL- RIGHT RIGHT GND SUBCKT
X2 VDD VDD SCL 0.1uF LID 0.1uF JNT SUBCKT
X3 QWIIC_RIGHT_ANGLE QWIIC_RIGHT_ANGLE QWIIC_RIGHT_ANGLE QWIIC_RIGHT_ANGLE SUBCKT
X4 INT ADR SCL 5DA N1 N2 SUBCKT
.end
