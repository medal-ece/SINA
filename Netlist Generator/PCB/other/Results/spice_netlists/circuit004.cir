* SPICE netlist for circuit004.png
X1 VBUS SBU2 SBU2 CC1 N1 D- SBU1 SBU1 CC2 N2 SUBCKT
X2 VBUS D- CC1 CC2 SBU1 SBU2 SBU2 GND SUBCKT
R3 N3 GND 1k
X4 N4 GND GND SUBCKT
.end
