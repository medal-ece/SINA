* SPICE netlist for circuit018.png
X1 VDD AINO SDA AIN1 ADDR AIN2 ALERT AIN3 ALERT GND SUBCKT
X2 JP2 N1 SCL ADDR ALERT ALERT SUBCKT
X3 AIN3 AIN2 AIN2 AINO AINO AINO SUBCKT
R4 N2 GND 1k
X5 CONN3G GND OSDA OSDA SCL SUBCKT
X6 GONN4GS1 VCC SDA SDA SCL SUBCKT
R7 N3 N4 1k
R8 N5 N6 1k
R9 N7 N8 1k
X10 N9 N10 N11 SUBCKT
X11 FERRITE SUBCKT
R12 FB3 FERRITE 1k
.end
