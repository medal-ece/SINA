* SPICE netlist for circuit050.png
X1 VCC SDA BCKP SCL CORE RXDIMOSI V_DCDC_OUT MISO D_SEL RTC RF_IN RTC EXTINT P1014 P1015 TIMEPULSE SAFEBDOT LNA RESET SQI SQI GND NC SUBCKT
X2 N1 N2 N3 N4 N5 N6 N7 N8 SUBCKT
X3 SCL SDA VCC GND- SUBCKT
X4 SAFEBOOT TIMEPULSE RESET INT SUBCKT
R5 O_SEL JP1 1k
.end
