* SPICE netlist for circuit005.png
X1 RAW RAW RESET RESET 3.3V A2 A1 A1 SCLK MISO MOSI MOSI MOSI SUBCKT
X2 DO D1 GND GND GND D3 D3 D5 D5 DZ DZ D9 D9 SUBCKT
X3 VBUS VBUS VBUS CC2 CC2 SBU1 SBU2 TYPE SUBCKT
X4 GND GPIO0 RUN GPIO1 GPIO2 IOVDD GPIO3 IOVDD GP104 IOVDD GPIO5 ADC_IOVDD GPIO6 GPIO7 DVDD VREG_VOUT GPIO8 GPIO9 USBBOOT TESTEN USBBOOT GPIO12 XIN GPIO13 XOUT GPIO14 GPIO17 GPIO26 GPIO25 NEOPIX GPIO26 NEOPIX GPIO26 GPIO18 GPIO28 GPIO19 GPIO29 GPIO20 GPIO21 GPIO22 QSPI_SCLK GPIO23 QSPI_SCLK DATA1 DATA1 USB QSPI_SD2 USB_D QSPI_SD2 SWCLK GND SWDIO SUBCKT
X5 A QSPL_SCK 3.3V MOSI QSPL_SCK OSPI OSPI HOLD GND GND SUBCKT
X6 IN OUT NSR0320 NSR0320 GND SUBCKT
X7 OGND OISDA CONN1G OISDA SUBCKT
X8 R4 D- USB_D D SUBCKT
X9 3.3V R10 OISDA R10 OSCL SUBCKT
R10 GND GND 1k
R11 3.3V 3.3V 1k
X12 3.3V NEOPIX DI XXX SUBCKT
R13 N1 N2 1k
X14 3.3V 3.3V N3 SUBCKT
R15 VBUS NSR0320 1k
R16 C20 GPIO26 1k
X17 VBUS GND GND SUBCKT
R18 RESET RESET 1k
R19 GND GND 1k
R20 SDA CONN1G 1k
.end
