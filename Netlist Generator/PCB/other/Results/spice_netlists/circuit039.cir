* SPICE netlist for circuit039.png
X1 VDD MODULE_RDY VDD RST COMI_RA COM1_TX ANT COM1_RTS ANT COM1 VANT COM2_RX USB COM2_TX USB_D COM2_RTS USB COM2_CTS ETHER COM3_RX ETHER COM3 ETHER COM3 ETHER COM3_CTS ETHER ETHER COM4_RX ETHER_TXD1 COM4_TX ETHER_TXDO ETHER SD_CLK ETHER SD_CMD ETHER_RST SD_DATA RTC_XTALI LOG_BTN RTC_XTALO LOG REF PPS_1V8 REF_OUT R6WW169K IN R7WW169K 2V8_OUT GPIO_1 1V8_OUT GPIO SYNC PVT_LED GP_LED2 ONOFF RSVD_NC PMIC_ON_REQ GND MOSAIC PMIC_ON_REQ SUBCKT
X2 N1 N2 N3 N4 N5 N6 SUBCKT
X3 N7 N8 N9 N10 N11 N12 N13 SUBCKT
X4 OUT OUT EN 1.0uF 3.3V SUBCKT
X5 N14 N15 COM3_RX COM3_TX COM3_CTS COM3_RTS N16 SUBCKT
X6 D13 D13 N17 PESDXL4 D13 N18 SUBCKT
X7 N19 N20 N21 N22 SUBCKT
X8 VBUS D D- USB USB SHLD GND JP1 JP1 SUBCKT
X9 SCK SUBCKT
X10 D9 N23 N24 PESDXL4 PESDXL4 SUBCKT
X11 N25 N26 N27 N28 J1 SUBCKT
X12 N29 N30 N31 N32 N33 GND N34 N35 SUBCKT
X13 N36 N37 N38 SUBCKT
X14 SOLDER SUBCKT
X15 EVENTB EVENTA PPS_3V3 LOG_BTN LED N39 N40 N41 SUBCKT
X16 D11 N42 N43 PE5DXL4 D11 D11 PE5DXL4 SUBCKT
X17 PMIC_ON_REQ LED LED MODULE_RDY RESET V_BAT V_USB VIN 3.3V N44 N45 SUBCKT
X18 D12 D12 N46 PESDXL4 D12 D12 PESDXL4 SUBCKT
X19 D14 N47 N48 PESDXL4UGUG D14 D14 PESDXL4UGUG PESDXL4UGUG N49 SUBCKT
X20 0.5A 6V 0.5A MEAS 0.5A F1 SUBCKT
X21 SOLDER VBUS D- GND GND SUBCKT
X22 VCC VCC VCC SUBCKT
.end
