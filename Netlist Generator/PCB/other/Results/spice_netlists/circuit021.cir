* SPICE netlist for circuit021.png
X1 VBUS #RST VBUS REGIN #SUSPEND SUSPEND GPIO0 GPIO1 GPIO1 GPIO2 GPIO3 VBUS RI D DCD D- DTR RXD0 CP2014VREG CP2014VREG TXDC RTS CTS SUBCKT
X2 3.3V NEOI2C_PWR NEOI2C_PWR SCK SCK TX TX RESET A2_5 A1 A2 A1 A2 A1 MOSI A1_1 MOSI A1_2 MISO A1 MISO SDA A2_8 DAC2 IXDO A2 IXDO X32P IO33 GND SUBCKT
X3 RESET GND AO_DAC2 AO_DAC2 DAC1 A2 A4 A4 SCK MOSI MOSI MISO TX TX N1 SUBCKT
X4 VBUS EN A12 A11 A10 A10 A9 A7 A7 SCL SCL SDA SUBCKT
X5 VBUS D- CC1 CC2 CC2 SBU1 SBU2 GND SUBCKT
X6 V_NEO12C VV DO GND NEOPIXEL DI SUBCKT
X7 CONN1G NEOI2C SDA SCL CONN1G SUBCKT
R8 N2 GND 1k
X9 VDD VBAT 5.1K STAT VSS SUBCKT
R10 R136 R136 1k
X11 OUT OUT EN GND GND SUBCKT
R12 10K 10K 1k
R13 5.1K 5.1K 1k
R14 N3 N4 1k
R15 N5 N6 1k
R16 N7 GND 1k
X17 OUT NEOI2C EN GND SCL SUBCKT
R18 JSTPH JSTPH 1k
R19 N8 GND 1k
R20 N9 N10 1k
X21 DMG3415U VHI EN SUBCKT
R22 N11 GND 1k
R23 3.3V SW 1k
R24 VBUS VBUS 1k
R25 N12 GND 1k
X26 VBAT VBAT N13 SUBCKT
R27 HH LIPO 1k
R28 47K 47K 1k
X29  SUBCKT
X30 N14 N15 N16 DUAL RESET Q52 SUBCKT
.end
