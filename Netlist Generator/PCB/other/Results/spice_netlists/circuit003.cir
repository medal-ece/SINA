* SPICE netlist for circuit003.png
X1 HOE PLM3 PWM2 PWM2 PUM4 PUM4 PUMS PUMZ PWM7 PUM9 PWM10 PWM10 PUM12 PUM13 PUM13 PUM14 PHM15 VDO VOD SCL PCA9685 PCA9685 SUBCKT
X2 PWMZ N1 R11013 LEND N2 R11013 R11013 PWM13 LAND LAND N3 GND SUBCKT
X3 PWM15 N4 LEND PWM14 N5 R120 PWM13 N6 LAND LAND GND N7 SUBCKT
X4 PWM3 N8 END PUM2 PUM19 R136 PWM1 N9 AND PUMA N10 GND SUBCKT
X5 PLM11 N11 LEND PUM19 N12 R146 R116 N13 LOND LOND N14 GND SUBCKT
X6 JP4 JP3 JP4 SDA DE SDA SDA SCI SCI DE SDA DE N15 SUBCKT
X7  SUBCKT
R8 N16 N17 1k
R9 GND GND 1k
R10 N18 N19 1k
R11 ND ND 1k
X12 PWM14 PWM14 PWM14 SUBCKT
X13 PWM3 PWM3 PWM3 SUBCKT
X14 GND N20 GND N21 SUBCKT
R15 OND OND 1k
X16 LEND LEND LEND LEND SUBCKT
X17 PLM11 PLM11 PLM11 SUBCKT
R18 PWM15 PWM15 1k
X19 PUM2 PUM2 PUM2 SUBCKT
R20 GND GND 1k
R21 PWMZ PWMZ 1k
R22 N22 N23 1k
R23 PUM19 PUM19 1k
R24 LEND R11013 1k
R25 PWM13 PWM13 1k
R26 PUMA PUMA 1k
R27 GND GND 1k
R28 UCC 5.8V 1k
R29 PUMB PUMB 1k
X30 PUM2 PUM2 PUM2 SUBCKT
R31 PUM19 PUM19 1k
X32 GND N24 N25 GND SUBCKT
X33 N26 N27 N28 N29 SUBCKT
R34 PWM1 PWM1 1k
.end
