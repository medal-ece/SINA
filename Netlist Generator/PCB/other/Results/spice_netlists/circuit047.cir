* SPICE netlist for circuit047.png
X1 POCI ISM SCL SDA N1 N2 JP1 JP1 SUBCKT
X2 SCL SDA UCC GND QWIIC_RIGHT_ANGLE SUBCKT
X3 ISM ISM MAG MAG_CS SDX TDQ TDQ SUBCKT
X4 SCL SDA UCC GND QWIIC_RIGHT_ANGLE SUBCKT
X5 VDDIO SDI VDD SCK CAP POCI MAG_CS GND MAG_INT MMC5983MA_QFN16 C2 SUBCKT
X6 OCS_AUX VDD VDD_10 GND GND SUBCKT
.end
