* SPICE netlist for circuit011.png
X1 GND #RST #SUSPEND SUSPEND GPIO0 GPIO1 GPIO2 GPIO3 RI DCD DTR RXDO RXDO TXDO RTS CTS GND CP2104 SUBCKT
X2 3.3V N1 GPIOO GPIO2 A2_0 SCK A2_5 A2 A2 A2 N2 MOSI MOSI MISO SCL SCL SDA DAC1 DAC2 A2 X32P X32N A13 A13 GND SUBCKT
X3 RESET N3 N4 DAC2 DAC1 N5 N6 N7 N8 N9 N10 N11 N12 N13 N14 SUBCKT
X4 JP3 N15 A12 A11 A10 A10 A9 A7 A7 A6 N16 N17 SUBCKT
X5 VDD VBAT PROG VSS SUBCKT
X6 VBUS D D- ID GND SUBCKT
R7 1K 1K 1k
X8 OUT OUT EN GND GND SUBCKT
R9 47K 47K 1k
R10 10K 10K 1k
R11 JSTPH JSTPH 1k
R12 R136 R136 1k
R13 A1 A1 1k
R14 N18 GND 1k
X15 THERMAL SUBCKT
R16 N19 N20 1k
X17 DMG3415U AP2112-3.3 EN EN SUBCKT
.end
