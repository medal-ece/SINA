* SPICE netlist for circuit002.png
X1 N1 ADC12_IN8 ADC12_IN9 BOOT1 FLASH JNTRST FLASH TIM4_CH1 TIM4_CH2 TIM4_CH3 TIM4_CH4 SCL 12C2_SDA PB12 SP12_SCK MOSI SPI2_MOSI ADC123_IN10 IN11 IN12 ADC123_IN13 ADC12_IN14 ADC12 USART6_TX USART6_RX SDIO TIM8_CH4 PC10 PC11 PC12 PC13 OSC32 OUT OSC SDIO_CMD SDIO_CMD SUBCKT
X2 GND SDA SDA SCL SUBCKT
X3 JP3 N2 N3 N4 N5 N6 N7 N8 N9 N10 N11 N12 SUBCKT
R4 JSTPH JSTPH 1k
X5 RESET N13 N14 A1 A1 A2 A4 A4 SCK MOSI MOSI MISO DO BOOTO BOOTO SUBCKT
X6 25Q16 VCC VSS SUBCKT
X7 VBUS VBUS D- CC1 CC2 CC2 SBU1 SBU2 GND SUBCKT
X8 CD1 DETECTD2 DETECTD2 DATA DATA SCLK D3 DAT1 DAT2 VSD GND MT2 MT1 SUBCKT
X9 N15 D8_NEOPIX DO GND SUBCKT
X10 VDD VBAT PROG STAT VSS SUBCKT
X11 N16 N17 SWDIO SWCLK N18 N19 N20 N21 N22 N23 N24 N25 SUBCKT
X12 OUT OUT OUT EN GND GND SUBCKT
R13 GND N26 1k
R14 N27 N28 1k
R15 DMG3405 EN 1k
X16 SD DETECTD2 N29 SUBCKT
R17 D- GND 1k
X18 N30 N31 N32 N33 SUBCKT
R19 N34 GND 1k
X20 VBAT N35 N36 SUBCKT
R21 N37 N38 1k
R22 N39 N40 1k
R23 N41 GND 1k
R24 N42 GND 1k
R25 N43 N44 1k
X26  SUBCKT
R27 N45 N46 1k
.end
