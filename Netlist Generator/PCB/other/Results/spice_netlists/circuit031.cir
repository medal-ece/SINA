* SPICE netlist for circuit031.png
X1 N1 EN N2 -D9 -D8 -D7 -D6 -DS -D4 -D3 N3 -D16 SUBCKT
X2 CORTEX_DEBUG RESET SWDIO SWDCLK SWO SUBCKT
X3 RESET N4 N5 N6 N7 N8 N9 N10 N11 N12 N13 N14 N15 N16 N17 N18 SUBCKT
X4 LORA LORA V_BT LORA_RF ANALOG BT_TX DIGITAL BT_ANT GPIOO GPIO21 GPIO1 GPIO22 GPIO2 GPIO23 GPIO3 GPIO24 GPIO4 GPIO25 GPIO5 GPIO26 GPIO6 GPIO27 GPIO7 GPIO28 GPIO8 GPIO29 GPIO9 GPIO30 GPIO10 GPIO31 GPIO11 GPIO32 GPIO12 GPIO33 GPIO13 GPIO34 GPIO14 GPIO35 GPIO15 GPIO37 GPIO16 GPI041 GPIO17 GPIO45 GPIO18 GPI046 GPIO19 GPIO48 GPIO20 GPIO49 NRESET LORA_DCSW LORA_VREG E9 F9 GND SUBCKT
X5 MCP73831 VBAT PROG STAT SUBCKT
X6 OUT OUT EN GND GND SUBCKT
.end
