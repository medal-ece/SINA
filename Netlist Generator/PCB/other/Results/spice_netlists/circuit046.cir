* SPICE netlist for circuit046.png
X1 VDD SDA VDD_10 SCL CS SDOI PICO_AUX SCX POCI_AUX OCS_AUX GND INT1 GND INT2 SUBCKT
X2 POCI CS SCL SDA N1 N2 SUBCKT
X3 INT2 INT1 OCS SCX PICO_AUX POCI_AUX SUBCKT
X4 ISCL SDA UCC GND SUBCKT
X5 ISCL SDA UCC GND- SUBCKT
.end
