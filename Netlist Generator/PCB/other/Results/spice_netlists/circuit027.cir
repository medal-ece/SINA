* SPICE netlist for circuit027.png
X1 VIO #RST VDD REGIN #SUSPEND SUSPEND GPIO0 GPIO1 GPIO1 GPIO3 GPIO3 VBUS DCD D DCD D- DSR DSR YPP RXD RXD RTS ONC CTS SUBCKT
X2 JP4 N1 RST GPIO3 GPIO3 #SUSP #SUSP SUSP SUBCKT
X3 RTS RXD RXD TXD DSR DCD DCD N2 SUBCKT
X4 RXD RXD TXD CTS CTS JP1 SUBCKT
X5 VBUS D D- ID GND SUBCKT
X6 THERMAL SUBCKT
R7 3.45V N3 1k
R8 3.45V N4 1k
.end
