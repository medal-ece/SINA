* SPICE netlist for circuit045.png
R1 R- B 1k
X2 Terminal Terminal Terminal Spring SUBCKT
X3 E- A- A- Shield Shield SUBCKT
X4 REFP AVDD VININ DVDD VINIP SDIO VIN2N SCLK VIN2P DRDY VBG XOUT REFN XIN AVSS DVSS SUBCKT
X5 -GND SCL SDA UCC -GND SUBCKT
X6 SCL SDA -UCC GND SUBCKT
X7 SCL SDA UCC GND SUBCKT
X8 J5 N1 INT SUBCKT
R9 qwik qwik 1k
.end
