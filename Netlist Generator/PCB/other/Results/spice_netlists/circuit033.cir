* SPICE netlist for circuit033.png
X1 IOVDD GPIO0 IOVDD GPIO1 USB GPIO2 IOVDD GPIO3 AVDD GPIO4 VREG GPIO5 VREG_LX GPIO6 VREG_FB GPIO7 DVDD GPIO8 GPIO9 RESET GPIO10 GPI011 USB GPIO12 USB_D- GPIO13 GPIO14 XIN GPIO15 XOUT GPIO16 GPIO17 SWDCK GPIO18 SWDIO PSRAM_CS SPI_POCI QSPI GPIO21 QSPI_SD1 SPI_SCK QSPI SPI_PICO QSPI_SD3 GPIO24 QSPI_SCLK GPIO25 QSPI_CS GPIO26 GPIO27 VREG GPIO28 PAD GPIO29 SUBCKT
X2 RAW GND RESET N1 A3 A2 A1 N2 SPI_SCK SPI_POCI SPI_PICO SPI_CS J4 SUBCKT
X3 TXB RX0 GND GND N3 N4 N5 N6 N7 N8 TX1 RX1 N9 SUBCKT
X4 OUT OUT CZ 10uF RT9080-33GJ5 RT9080-33GJ5 SUBCKT
X5 QWIIC_RIGHT_ANGLE QWIIC_RIGHT_ANGLE QWIIC_RIGHT_ANGLE QWIIC_RIGHT_ANGLE QWIIC_RIGHT_ANGLE SUBCKT
X6 SOLDER_PADS SOLDER_PADS SOLDER_PADS SOLDER_PADS JP14 SUBCKT
X7 VBUS RP_D RP_D- USB USB SHLD GND N10 GND SUBCKT
X8 VDD PSRAM_CS QSPI QSPI QSPI QSPI SI03 QSPI APS6404L SUBCKT
X9 VDD CS QSPI QSPI QSPI QSPI 0.1uF QSPI W25QXX128MBIT SUBCKT
X10 WV WS2812 WS2812 WS2812_2020 DO SUBCKT
X11 6V D2 6V SUBCKT
.end
