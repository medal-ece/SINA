* SPICE netlist for circuit043.png
X1 VCC PB5 HDRIZONTAL VERTICAL PB2 MISO PBO PBO SUBCKT
X2 SCL SDA VCC GND SUBCKT
X3 N1 N2 VERTICAL N3 JOYSTICK HORIZONTAL JOYSTICK 5ELECT SEL- SUBCKT
X4 SCL SDA VCC GND SUBCKT
X5 SELECT GND SELECT SDA SCL GND SUBCKT
X6 Port Port N4 12C SUBCKT
.end
