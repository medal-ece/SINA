* SPICE netlist for circuit012.png
X1 VIN1 YOUT1 VIN2 VOUT2 VPCC PG VBAT1 STAT2 VBAT2 STAT1 VBATSENS SEL PROG2 THERM TE CE VSS1 PROG1 VSS2 PROG3 THERMAL SUBCKT
X2 SW YOUT ENABLE ENABLE FB LBI SYNC LBO GND PGND SUBCKT
X3 VBAT N1 ENABLE ENABLE N2 N3 N4 SUBCKT
X4 CN1 VBUS D USBA_FEMALE D GND SUBCKT
X5 VBUS D D- ID GND SUBCKT
R6 R5 R5 1k
R7 N5 N6 1k
R8 340K 340K 1k
R9 T1 N7 1k
X10 N8 LBO N9 MENN2133LT1G SUBCKT
R11 15K 15K 1k
R12 1,87m 1,87m 1k
X13 N10 GND GND SUBCKT
R14 R11 R11 1k
R15 N11 N12 1k
R16 GND R12 1k
R17 VBAT N13 1k
R18 N14 N15 1k
R19 43K 43K 1k
R20 N16 GND 1k
R21 VBUS N17 1k
R22 N18 GND 1k
R23 N19 N20 1k
R24 43.3K 43.3K 1k
.end
