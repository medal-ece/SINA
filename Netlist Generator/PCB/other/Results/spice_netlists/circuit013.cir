* SPICE netlist for circuit013.png
X1 CONN3G GND OSDA OSDA SCL SUBCKT
X2 N1 SCL SDA SQW SQW SUBCKT
X3 GONN4GS1 VCC SDA SDA SCL SUBCKT
X4 VDD XI INTI CLK SCL VBAT SDA VSS SUBCKT
R5 N2 N3 1k
R6 SDA SDA 1k
R7 1K 1K 1k
R8 N4 N5 1k
R9 VCC N6 1k
.end
