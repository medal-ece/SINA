* SPICE netlist for circuit036.png
X1 VCC ADC7 AVCC ADC6 RESET ADC5 AREF ADC4 ADC1 ADCO VBUS PD2 UVCC TXO UCAP SDA PDO D ADC8 D. PC6 ADC10 PE6 ADC11 XTAL1 ADC12 ADC13 XTAL2 PB7 ADC9 PE2 ADC9 PBO SCK MOSI MISO GND PD5 SUBCKT
X2 TXO RXI GND GND SDA SCL D4 D5 D6 D7 D8 D9 SUBCKT
X3 OUT OUT C7 10uF 10uF SUBCKT
X4 VBUS A7 A7 USB SHLD1 SHLD1 GND SUBCKT
X5 RAW GND RESET VCC A3 A2 A1 AO SCK MISO MOSI D10 SUBCKT
X6 VBUS D- GND GND SUBCKT
X7 SCL SDA UCC GND- SUBCKT
X8 0.5A F1 0.5A 6V SUBCKT
X9 N N 22pF SUBCKT
.end
