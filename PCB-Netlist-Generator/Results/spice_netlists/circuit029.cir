* SPICE netlist for circuit029.png
X1 VCC IN OUT IN GND SUBCKT
X2 JP1 N1 N2 SUBCKT
R3 FB1 FERRITE 1k
X4 AVCC N3 N4 SUBCKT
R5 N5 AGND 1k
R6 1K N6 1k
R7 22K TC33X 1k
R8 B B 1k
.end
