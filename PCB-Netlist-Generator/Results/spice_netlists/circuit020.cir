* SPICE netlist for circuit020.png
X1 VCC CA1 CA3 CA3 CA5 CA5 CA6 SDA CA8 ADDR CA8 ADDR CA9 INTB AUDIOIN CB1 CB3 CB4 SHUTDOWN CB4 CB6 R_EXT CB6 C_FILT CB8 CB9 GND CB9 SALS2 SUBCKT
X2 JP4 N1 N2 N3 N4 N5 N6 N7 SHUTDOWN SHUTDOWN N8 N9 N10 SUBCKT
X3 JP2 N11 N12 N13 N14 N15 N16 N17 N18 N19 N20 N21 N22 SUBCKT
X4 JP5 SCL SCL AUDIOIN AUDIOIN SHUTDOWN SHUTDOWN SUBCKT
R5 SHUTDOWN SHUTDOWN 1k
R6 RG ADDR 1k
R7 Whakch Whakch 1k
R8 Whakch Whakch 1k
R9 Whakch Whakch 1k
.end
