* SPICE netlist for circuit001.png
X1 N1 MISO SCK MOSI RST 2X3THM SUBCKT
X2 C1 C1 C1 100uF 0.1uF N2 SUBCKT
X3 VCC SUBCKT
X4 N3 SUBCKT
X5 PCINTO PCINT1 PCINT2 PCINT3 VCC PCINT4 GND PCINT5 SUBCKT
R6 RST N4 1k
.end
