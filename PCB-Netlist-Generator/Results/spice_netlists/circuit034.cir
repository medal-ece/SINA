* SPICE netlist for circuit034.png
X1 RXD1020 3V3 IOAO RESET IOA1 10A2 IOA3 MTMS MTDI MTCK MTD0 N1 N2 N3 D- D RXD1020 GND TXD021 ESP32 SUBCKT
X2 N4 N5 N6 N7 N8 N9 N10 N11 N12 1X09_CASTELLATED 1X09_CASTELLATED SUBCKT
X3 IG21 IO N13 N14 N15 N16 N17 I016 N18 CASTELLATED CASTELLATED CASTELLATED SUBCKT
X4 OUT OUT EN 2,2uF RT9088-33GJ5 SUBCKT
X5 SCL SDA VCC GND Connector SUBCKT
X6 SHLD SUBCKT
X7 VBUS D- GND GND SUBCKT
.end
