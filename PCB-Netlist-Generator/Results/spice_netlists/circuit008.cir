* SPICE netlist for circuit008.png
X1 N1 RESET N2 AREF GND GPIOAO GPIOA1 GPIOA2 GPIOA3 GPIOA4 GPIOA5 GPIOSCK GPIOMOSI GPIOMISO GPIORX GPIOTX NC SUBCKT
X2 N3 N4 N5 SUBCKT
R3 1BK 1BK 1k
X4 RELAYSIGNAL SUBCKT
R5 1K 1K 1k
R6 RELAYSIGNAL MMBT2222 1k
.end
