* SPICE netlist for circuit022.png
X1 3.3V 5.0V SDA 5.0V SCL TXD GPIO4 RXD GND GPIO18 GPIO17 GPIO18 GPIO21 GPIO23 GPIO22 GPIO23 MOSI GPIO24 MOSI GPIO25 SCLK23 GPIO25 SPI_SCLK #SPI_CEO EEDATA SPI_CE1 EEDATA EECLK GPIO5 GPIO12 GPIO6 GPIO12 GPIO13 GPIO16 GPIO19 GPIO20 GPIO26 GPIO21 GND GPIO21 SUBCKT
X2 VDD PWMO PWM1 SDA PWM2 SCL PWM3 PWM4 #OE PWM5 PWM6 EXTCLK PWM7 A1 PWM8 A1 PWM9 A2 PWM10 A4 PYYM11 A4 PWM12 A5 PWM13 PWM14 GND PWM15 SUBCKT
X3 N1 N2 N3 N4 N5 N6 N7 N8 N9 N10 N11 N12 N13 N14 N15 N16 N17 N18 N19 N20 N21 N22 N23 N24 N25 SUBCKT
X4 TB6612FNG VM1 A01 A01 PWMA AIN2 PGND1 AIN1 PGND1 VCC A02 STBY A02 GND BO2 B02 BIN1 BIN2 PGND2 PWMB PGND2 VM3 B01 VM2 B01 SUBCKT
X5 A01 VM1 A01 PWMA PGND1 PWM10 PGND1 PWM10 A02 VCC A02 STBY B02 GND BO2 PHAM11 PGND2 PWM13 PGND2 PWM13 B01 VM3 B01 VM2 SUBCKT
X6 PWM14 PWM14 PWMO PWMO SUBCKT
R7 N26 N27 1k
X8 N28 SUBCKT
X9 N29 N30 N31 N32 N33 SUBCKT
X10 AZI N34 N35 SUBCKT
R11 10K 10K 1k
R12 N36 N37 1k
.end
